* Testbench for extracted Sky130 CMOS Inverter

.lib "/home/dhruvrathod/EDA/open_pdks/sky130/sky130A/libs.tech/ngspice/sky130.lib.spice" tt
.include "CMOS_Inverter_Try.spice"
.option scale=1u

Vcc Voltage_VCC 0 DC 1.8V
Vgnd Voltage_GND 0 DC 0V
Vin Vin_Gate_Location2 0 PULSE(0V 1.8V 0s 10ps 10ps 5ns 10ns)

.control
  run
  dc Vin 0 1.8 0.01
.endc

.end
